procedure(pcGenCell_test_cell ()
    let((cv)
        cv = ddGetObj("mytech" "test_cell")
        rodCreateRect("diff" 1.0 2.0)
    )
)
